# Ansys Electronics Desktop project, version 2024.1
materials:
  vacuum: permittivity=1
  polystyrene_inner: permittivity=2.6 conductivity=1e-16
  polystyrene_middle: permittivity=2.6 conductivity=1e-16
  polystyrene_very_inner: permittivity=2.6 conductivity=1e-16
  PVC plastic: permittivity=2.7 dielectric_loss_tangent=0.007
  steel_stainless: conductivity=1100000

design HFSSDesign1 (HFSS, HFSS Terminal Network, model units mm)
geometry:
  CutExtrude2 [steel_stainless] = imported_body(/home/admin/Desktop/fullydefined/luneburg_plate_assem_fully_defined.STEP)
  Fillet51 [PVC plastic] = imported_body(/home/admin/Desktop/fullydefined/luneburg_plate_assem_fully_defined.STEP)
  CutExtrude11, CutExtrude12 [polystyrene_inner] = imported_body(/home/admin/Desktop/fullydefined/luneburg_plate_assem_fully_defined.STEP)
  CutExtrude13, CutExtrude14 [polystyrene_middle] = imported_body(/home/admin/Desktop/fullydefined/luneburg_plate_assem_fully_defined.STEP)
  CutExtrude15, CutExtrude16 [polystyrene_very_inner] = imported_body(/home/admin/Desktop/fullydefined/luneburg_plate_assem_fully_defined.STEP)
  RadiatingSurface [vacuum] = region(absolute_offset=41.666667mm on all sides)
  group luneburg_plate_assem_fully_defined = CutExtrude2, Fillet51
  group lens_with_air_gap = CutExtrude11..CutExtrude16
boundaries and excitations:
  Open1: Radiation Objects=RadiatingSurface
  IncPWave1: Plane Incident Wave IsCartesian EoX=0 EoY=0 EoZ=1 kX=1 kY=0 kZ=0 OriginX=-86.411mm OriginY=0mm OriginZ=0mm IsPropagating
setups:
  Setup1: HfssDrivenAuto AutoSolverSetting=Balanced Type=Discrete
    sweep Sweep: 2.35GHz to 2.45GHz step 0.05GHz;
source amplitudes:
  IncPWave1:1: 1 0deg
radiation setups:
  3D: Infinite Sphere Theta=0deg..180deg step 2deg Phi=-180deg..180deg step 2deg
  Elevation: Infinite Sphere Theta=-180deg..180deg step 1deg Phi=0deg..90deg step 90deg
  Azimuth: Infinite Sphere Theta=90deg..90deg step 0deg Phi=-180deg..180deg step 1deg
reports:
  Directivity Plot 1: DirTotal vs Phi, Theta on Setup1 : Sweep, 3D [Freq=2.4GHz]
  Directivity Plot 2: DirTotal vs Phi, Theta on Setup1 : Sweep, 3D [Freq=2.4GHz]
  Directivity Plot 3: DirTotal vs Phi, Theta on Setup1 : Sweep, 3D [Freq=2.4GHz]
  Directivity Plot 4: DirTotal vs Phi, Theta on Setup1 : Sweep, 3D [Freq=2.4GHz]
